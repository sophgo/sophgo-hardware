| IBIS Models Generator: Lattice Diamond (64-bit) 3.12.1.454
| Generate date: Wed Jul 12 16:08:05 2023
| IBIS File LibisMaker.ibs
| LibisGen v2.0.1.0, 02/25/2008, Lattice Semiconductor Corporation
| Modified by LibisMaker v2.0.1.0, 02/25/2008, Lattice Semiconductor
| North Carolina State University, ERL, 2006
[IBIS ver]   3.2
[File Name]   Server_CPLD_V11_PRJ~.ibs
[File Rev]   2.1
[Date]   Wed Jul  1 08:34:36 PDT 2020
[Source]   Lattice Semiconductor cs200fl Process
   LCMXO3LF-2100C   FINAL
   Lattice Semiconductor has worked hard to ensure the
   models below are accurate and complete.  However, the
   data below was generated using simulation of the
   input/output model files for the silicon.  Therefore,
   the data below is for reference and initial design
   purposes only.
   Lattice Semiconductor grants permission to use this
   data for use in printed circuit design using this
   Lattice programmable logic device.  Other use of this
   code, including the selling or duplication of any
   portion is strictly prohibited.
|   NAMING CONVENTION
   The IBIS [Model] header is limited by the specification to a
   total of characters.  With such a set of characters available
   for naming models it becomes important to attempt to
   meaningfully encode the IO standards so they fit within the
   twenty character limit.  It would seem that twenty characters
   would provide room enough for describing IO's.  However, the
   PLD IO structure continues to grow more and more complex.  The
   complexity is making the twenty characters insuffiently
   descriptive.  In order to overcome this issue the naming
   convention described below is implemented to resolve the issue.
The twenty character space is managed as follows:
   bbbvvvsdddprugtcoixx
   b = standard
   v = voltage (x.xx V)
   s = slew code
   d = drive (xx.x ma)
   p = pullup code
   r = series resistance  or bank_vccio code
   u = terminate to vcc code
   g = terminate to gnd code
   t = terminate to vtt code
   c = common mode termination mode
   o = diff resistor code
   i = diff resistor current code
   x = reserved
   standard
   LVCMOS   lvc
   lvcmosd   lvd
   lvcmosr   lvr
   LVDS25E   lve
   LVTTL   lvt
   lvttld   ltd
   PCI   pci
   pcix   pcx
   lvds25   lvs
   blvds25   blv
   blvds25e   blv
   mlvds25   mlv
   mlvds25e   mlv
   lvpecl33   lvp
   lvpecl33e   lvp
   cml   cml
   hypt   hyp
   rsds25   rsd
   rsds25e   rse
   mipi_lp   mip
   mipi   mip
   vref1   vr1
   vref2   vr2
   ref_res   rer
   slew
   na   a
   fast   f
   slow   s
   pullmode
   off   a
   pullup   b
   pulldown   c
   bushold   d
   clamp   e
   up_clamp   f
   down_clamp   g
   keeper_clamp   h
   impedance or Bank_vccio
   off   a
   25   b
   33   c
   50   d
   100   e
   3.3   f
   2.5   g
   1.8   h
   1.5   i
   1.2   j
   termVCC
   off   a
   50   b
   100   c
   120   d
   termGND
   off   a
   50   b
   100   c
   120   d
   termVTT
   off   a
   60   b
   75   c
   120   d
   150   e
   210   f
   VCMT
   off   a
   VCMT   b
   VTT   c
   DDR-2   d
   differential resistor
   off   a
   100   b
   diff drive
   NA   a
   2.0   b
   3.5   c
   1.25   f
   2.5   g
   Reserved   IO type
   in   input only
   ou   output
   io   I/O
   od   Open drain
   on   Inverting differential I/O
   (signal name only)
   op   Non-Inverting differential I/O
   (signal name only)
   Lattice Semiconductor Corporation
   5555 NE Moore Court
   Hillsboro, OR 97214
   U.S.A
   TEL: 1-800-Lattice (USA and Canada)
   408-826-6000 (other locations)
   web: http://www.latticesemi.com/
   email: techsupport@latticesemi.com
[Disclaimer] This IBIS source code is intended as a design reference
   which illustrates how the Lattice Semiconductor device operates.
   It is the user's responsibility to verify their design for
   consistency and functionality through the use of formal
   verification methods.  Lattice Semiconductor provides no warranty
   regarding the use or functionality of this data.
[Copyright]   Copyright 2007 by Lattice Semiconductor Corporation
|   Component XO3L
[Component]   XO3L
[Manufacturer]   Lattice Semiconductor Corp.
[Package]
|CABGA256
| variable   typ   min   max
R_pkg   138.8m   126.7m   150m
L_pkg   5.59nH   3.24nH   8.59nH
C_pkg   .281pF   .275pF   .288pF
[Pin] signal_name   model_name   R_pin   L_pin   C_pin
T3   a_gpio2   lvc180s080caaaaaaaou
R4   a_gpio3   lvc180axxxghaaaaaain
P8   a_gpio5   lvc180axxxghaaaaaain
J1   bmc_extrst   lvc330s080caaaaaaaou
G2   bmc_gpio24   lvc330axxxgfaaaaaain
G3   bmc_gpio25   lvc330axxxgfaaaaaain
G6   bmc_gpio48   lvc330axxxgfaaaaaain
G5   bmc_gpio49   lvc330axxxgfaaaaaain
F3   bmc_gpio51   lvc330s160baaaaaaaou
F1   bmc_gpio53   lvc330s080caaaaaaaou
C2   bmc_gpio54   lvc330s080caaaaaaaou
L12   bmc_pcie_rst   lvc330s080caaaaaaaou
D10   bmc_pwrgd   lvc330s080caaaaaaaou
A9   bmc_scl   lvc330s080caaaaaaaou
C9   bmc_sda   lvc330s080gaaaaaaaio
N1   bmc_srst   lvc250s160afaaaaaaod
L1   bmc_ssprst   lvc330s080caaaaaaaou
K2   bp_ncp_d_oc   lvc330axxxgfaaaaaain
K3   bp_ncp_gok   lvc330axxxgfaaaaaain
C8   clock   lvc330axxxgfaaaaaain
M1   cpld_extrst   lvc330axxxgfaaaaaain
P2   cpld_heart   lvc330s080aaaaaaaaou
P15   cpld_led_test   lvc330s040aaaaaaaaou
P5   cpua_sys_reset   lvc180s040caaaaaaaou
N7   cpub_sys_reset   lvc180s040caaaaaaaou
D2   ddr0_event_a   lvc180axxxgfaaaaaain
P6   ddr0_event_b   lvc180axxxghaaaaaain
T4   ddr1_event_a   lvc180axxxghaaaaaain
T6   ddr1_event_b   lvc180axxxghaaaaaain
T2   ddr2_event_a   lvc180axxxghaaaaaain
R7   ddr2_event_b   lvc180axxxghaaaaaain
R3   ddr3_event_a   lvc180axxxghaaaaaain
P7   ddr3_event_b   lvc180axxxghaaaaaain
F9   e2prom_scl   lvc330s080gaaaaaaaio
E11   e2prom_sda   lvc330s080gaaaaaaaio
J11   en_12v_bp   lvc330s080caaaaaaaou
K11   en_3v3_riser   lvc330s080caaaaaaaou
B11   en_bp_5v   lvc330s080caaaaaaaou
C4   en_ddr_phy_a   lvc330s080caaaaaaaou
C16   en_ddr_phy_b   lvc330s080caaaaaaaou
H4   en_pcie_h_a   lvc330s080caaaaaaaou
J6   en_pcie_h_b   lvc330s080caaaaaaaou
B12   en_pcie_phy_a   lvc330s080caaaaaaaou
K14   en_pcie_phy_b   lvc330s080caaaaaaaou
A4   en_pcie_sw_0v8_a   lvc330s080caaaaaaaou
N15   en_pcie_sw_0v8_b   lvc330s080caaaaaaaou
E16   en_vdd_12v   lvc330s080caaaaaaaou
A11   en_vdd_1v8   lvc330s080caaaaaaaou
B13   en_vdd_3v3   lvc330s080caaaaaaaou
F10   en_vdd_5v   lvc330s080caaaaaaaou
A15   en_vddc_a   lvc330s080caaaaaaaou
B5   en_vddc_b   lvc330s080caaaaaaaou
E7   en_vddq_a0   lvc330s080caaaaaaaou
E6   en_vddq_a1   lvc330s080caaaaaaaou
E9   en_vddq_b0   lvc330s080caaaaaaaou
B6   en_vddq_b1   lvc330s080caaaaaaaou
D7   en_vpp_a0   lvc330s080caaaaaaaou
F7   en_vpp_a1   lvc330s080caaaaaaaou
D9   en_vpp_b0   lvc330s080caaaaaaaou
D15   en_vpp_b1   lvc330s080caaaaaaaou
C5   en_vqps18_a   lvc330s080caaaaaaaou
R16   en_vqps18_b   lvc330s080caaaaaaaou
E15   en_vtt_a0   lvc330s080caaaaaaaou
D14   en_vtt_a1   lvc330s080caaaaaaaou
E14   en_vtt_b0   lvc330s080caaaaaaaou
D16   en_vtt_b1   lvc330s080caaaaaaaou
K16   fm_pwr_btn   lvc330axxxgfaaaaaain
K6   ncp0_d_oc   lvc330axxxgfaaaaaain
J5   ncp0_gok   lvc330axxxgfaaaaaain
H15   pcie_nvme0_rst   lvc330s080caaaaaaaou
G1   pcie_nvme1_rst   lvc330s080caaaaaaaou
G16   pcie_sata_rst   lvc330s080caaaaaaaou
R13   pcie_swa_prst   lvc180s080caaaaaaaou
R11   pcie_swa_sys_rst   lvc180s080caaaaaaaou
T14   pcie_swb_prst   lvc180s080caaaaaaaou
T12   pcie_swb_sys_rst   lvc180s080caaaaaaaou
G14   pcie_usb0_rst   lvc330s080caaaaaaaou
L2   pcie_usb1_rst   lvc330s080caaaaaaaou
L13   pg_3v3_riser   lvc330axxxgfaaaaaain
L3   pg_5v_aux   lvc330axxxgfaaaaaain
A12   pg_bp_5v   lvc330axxxgfaaaaaain
H11   pg_ddr_phy_a   lvc330axxxgfaaaaaain
B16   pg_ddr_phy_b   lvc330axxxgfaaaaaain
M8   pg_pcie_h_a   lvc180axxxghaaaaaain
N9   pg_pcie_h_b   lvc180axxxghaaaaaain
C12   pg_pcie_phy_a   lvc330axxxgfaaaaaain
C15   pg_pcie_phy_b   lvc330axxxgfaaaaaain
E10   pg_pcie_sw_0v8_a   lvc330axxxffaaaaaain
P16   pg_pcie_sw_0v8_b   lvc330axxxffaaaaaain
C11   pg_vdd_1v8   lvc330axxxgfaaaaaain
A14   pg_vdd_3v3   lvc330axxxgfaaaaaain
D11   pg_vdd_5v   lvc330axxxgfaaaaaain
B14   pg_vddc_a   lvc330axxxgfaaaaaain
A10   pg_vddc_b   lvc330axxxgfaaaaaain
F8   pg_vddq_a0   lvc330axxxgfaaaaaain
F13   pg_vddq_a1   lvc330axxxgfaaaaaain
B3   pg_vddq_b0   lvc330axxxgfaaaaaain
D8   pg_vddq_b1   lvc330axxxgfaaaaaain
B4   pg_vpp_a0   lvc330axxxgfaaaaaain
D6   pg_vpp_a1   lvc330axxxgfaaaaaain
A3   pg_vpp_b0   lvc330axxxgfaaaaaain
B9   pg_vpp_b1   lvc330axxxgfaaaaaain
C7   pg_vtt_a0   lvc330axxxgfaaaaaain
A5   pg_vtt_a1   lvc330axxxgfaaaaaain
E8   pg_vtt_b0   lvc330axxxgfaaaaaain
A8   pg_vtt_b1   lvc330axxxgfaaaaaain
H12   psu0_alert   lvc330axxxgfaaaaaain
J12   psu0_prsnt   lvc330axxxgfaaaaaain
G12   psu0_pwrok   lvc330axxxefaaaaaain
H13   psu1_alert   lvc330axxxgfaaaaaain
J16   psu1_prsnt   lvc330axxxgfaaaaaain
F12   psu1_pwrok   lvc330axxxefaaaaaain
G13   psu_ps_on_cpld   lvc330s080caaaaaaaou
R5   pwr_button_a   lvc180s080baaaaaaaou
M7   pwr_button_b   lvc180s080baaaaaaaou
F14   riser0_reset   lvc330s080caaaaaaaou
H14   riser0_slot16a_prsnt lvc330axxxgfaaaaaain
H16   riser0_slot16b_prsnt lvc330axxxgfaaaaaain
K13   riser0_slot_id0   lvc330axxxgfaaaaaain
K12   riser0_slot_id1   lvc330axxxgfaaaaaain
L15   riser0_slot_id2   lvc330axxxgfaaaaaain
F16   riser1_reset   lvc330s080caaaaaaaou
N16   riser1_slot16a_prsnt lvc330axxxgfaaaaaain
N14   riser1_slot16b_prsnt lvc330axxxgfaaaaaain
M16   riser1_slot_id0   lvc330axxxgfaaaaaain
M14   riser1_slot_id1   lvc330axxxgfaaaaaain
M15   riser1_slot_id2   lvc330axxxgfaaaaaain
G15   riser2_reset   lvc330s080caaaaaaaou
L4   riser2_slot16b_prsnt lvc330axxxgfaaaaaain
K4   riser2_slot_id0   lvc330axxxgfaaaaaain
L5   riser2_slot_id1   lvc330axxxgfaaaaaain
P10   sg0_pcie1_l0_reset   lvc180axxxghaaaaaain
P11   sg1_pcie0_l0_reset   lvc180axxxghaaaaaain
P1   sys_uart_rxd3   lvc330s080baaaaaaaou
K5   sys_uart_txd3   lvc330axxxgfaaaaaain
T9   uart0_rx_a   lvc180s080baaaaaaaou
P12   uart0_rx_b   lvc180s080baaaaaaaou
P9   uart0_tx_a   lvc330axxxahaaaaaain
T13   uart0_tx_b   lvc330axxxahaaaaaain
R9   uart1_rx_a   lvc180s080baaaaaaaou
R12   uart1_rx_b   lvc180s080baaaaaaaou
T10   uart1_tx_a   lvc330axxxahaaaaaain
P13   uart1_tx_b   lvc330axxxahaaaaaain
N2   usb1_ponrst   lvc330s080caaaaaaaou
J3   usb2_ponrst   lvc330s080caaaaaaaou
M2   vga_6505_in1   lvc330s080caaaaaaaou
N3   vga_6505_in2   lvc330s080caaaaaaaou
| Models and submodels in the file (16): lvc180axxxgfaaaaaain (Input), lvc180axxxghaaaaaain (Input), lvc180s040caaaaaaaou (Output), lvc180s080baaaaaaaou (Output), lvc180s080caaaaaaaou (Output), lvc250s160afaaaaaaod (I/O_open_drain), lvc330axxxahaaaaaain (Input), lvc330axxxefaaaaaain (Input), lvc330axxxffaaaaaain (Input), lvc330axxxgfaaaaaain (Input), lvc330s040aaaaaaaaou (Output), lvc330s080aaaaaaaaou (Output), lvc330s080baaaaaaaou (Output), lvc330s080caaaaaaaou (Output), lvc330s080gaaaaaaaio (I/O), lvc330s160baaaaaaaou (Output)
